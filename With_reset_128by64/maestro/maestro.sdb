ADE simulation setup
Run mode: Single Run, Sweeps and Corners
Tests:
  Memory_With_reset_128by64_1: Memory/With_reset_128by64/schematic, simulator spectre
    Outputs: VT("/BL_b<63:0>"); VT("/BL<63:0>")
Global variables:
  VDD = 1
