ADE simulation setup
Test Memory_With_reset_128by64_1: Memory/With_reset_128by64/schematic, simulator spectre
  Models: /afs/ece.cmu.edu/class/ece622/cad_setup/gpdk045_v_2_0/models/spectre/gpdk045.scs[tt]
  Temperature: 27
  Files: vectors /afs/ece.cmu.edu/usr/tongwu2/cadence/gpdk045_virtuoso/vec/sram128x64_bl_reset.vec
  Analysis tran: stop=7n
  Output VT("/BL<63:0>")
  Output VT("/BL_b<63:0>")
  Output VT("/WL<127:0>")
  Output VT("/BL_reset_b")
  Signals: /BL_b<63:0>, /BL<63:0>, /WL<127:0>, /BL_reset_b
Run mode: Single Run, Sweeps and Corners
Global variables:
  VDD = 1
