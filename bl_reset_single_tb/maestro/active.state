ADE simulation setup
Test Memory_bl_reset_single_tb_1: Memory/bl_reset_single_tb/schematic, simulator spectre
  Models: /afs/ece.cmu.edu/class/ece622/cad_setup/gpdk045_v_2_0/models/spectre/gpdk045.scs[tt]
  Temperature: 27
  Files: vectors /afs/andrew.cmu.edu/usr6/dchinmay/private/Srimani_Lab/Cadence/vec/bl_reset_tb.vec
  Analysis tran: stop=2n
  Signals: /bl_reset_b, /BL_b, /BL
Run mode: Single Run, Sweeps and Corners
