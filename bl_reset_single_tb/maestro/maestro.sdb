ADE simulation setup
Run mode: Single Run, Sweeps and Corners
Tests:
  Memory_bl_reset_single_tb_1: Memory/bl_reset_single_tb/schematic, simulator spectre
