ADE simulation setup
Test Memory_128by64_TB_1: Memory/128by64_TB/schematic, simulator spectre
  Models: /afs/ece.cmu.edu/class/ece622/cad_setup/gpdk045_v_2_0/models/spectre/gpdk045.scs[tt]
  Temperature: 27
  Files: vectors /afs/ece.cmu.edu/usr/tongwu2/cadence/gpdk045_virtuoso/vec/sram128x64.vec
  Analysis tran: stop=2n
  Output VT("/BL_b<63:0>")
  Output VT("/BL<63:0>")
  Output VT("/WL<127:0>")
  Signals: /WL<127:0>, /BL<63:0>, /BL_b<63:0>
Run mode: Single Run, Sweeps and Corners
