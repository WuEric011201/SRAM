ADE simulation setup
Run mode: Single Run, Sweeps and Corners
Tests:
  Memory_128by64_TB_1: Memory/128by64_TB/schematic, simulator spectre
    Outputs: VT("/BL<63:0>"); VT("/BL_b<63:0>")
